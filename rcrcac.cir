.title dual rc ladder
* file name rcrcac.cir
R1 int in 10k
V1 in 0 dc 0 ac 1 PULSE (0 5 1u 1u 1u 10m 100m)
R2 out int 10k
C1 int 0 100n
C2 out 0 100n
R3 out 0 1meg

.control
ac dec 10 1 100k
*settype decibel out
*plot vdb(int) xlimit 1 100k ylabel 'small signal gain'
*settype phase out
*plot cph(int) xlimit 1 100k ylabel 'phase (in rad)'
let intd = 180/PI*cph(int)
settype phase intd
plot intd xlimit 1 100k ylabel 'phase'
let outd = 180/PI*cph(out)
settype phase outd
plot outd xlimit 1 100k ylabel 'phase'
.endc

.end
