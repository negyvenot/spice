.title dual rc ladder

V1 in0 0 dc 0 ac 1 PULSE (0 .0005 1u 1u 1u 2m 1)

R0 in0 in 100k
Rf in e0 100k

C1 int in 15n
C2 int out 15n
R1 int 0 10k
R2 out 0 10k
E1 out 0 e0 0 -600

*.ac dec 10 10 100k

.control
* settype decibel out
tran 100u 1
plot out
*plot db(ac1.v(out)) db(ac2.v(out)) db(ac3.v(out)) db(ac4.v(out)) db(ac5.v(out)) db(ac6.v(out))
*plot ac1.v(out) ac2.v(out) ac3.v(out) ac4.v(out) ac5.v(out) ac6.v(out)

.endc

.end
